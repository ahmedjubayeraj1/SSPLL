* sspll_cco (step 75): ports VDDA VDDD VDDL VSS vring ibias vtest code0..code4 pll_en vtest_en
.subckt sspll_ls_1v8_3v3 in out outb VDDD VDDA VSS
* 1.8 V -> 3.3 V level shifter: thin-oxide input inverter on VDDD, thick-oxide cross-coupled pMOS load,
* thick-oxide pull-downs driven by in / inb, thick-oxide output inverters (out follows in, outb is its inverse)
xpi inb in VDDD VDDD sky130_fd_pr__pfet_01v8 w=1 l=0.15 nf=1 m=1
xni inb in VSS VSS sky130_fd_pr__nfet_01v8 w=0.5 l=0.15 nf=1 m=1
xp1 x y VDDA VDDA sky130_fd_pr__pfet_g5v0d10v5 w=1 l=0.5 nf=1 m=1
xp2 y x VDDA VDDA sky130_fd_pr__pfet_g5v0d10v5 w=1 l=0.5 nf=1 m=1
xn1 x in VSS VSS sky130_fd_pr__nfet_g5v0d10v5 w=3 l=0.5 nf=1 m=1
xn2 y inb VSS VSS sky130_fd_pr__nfet_g5v0d10v5 w=3 l=0.5 nf=1 m=1
xpo out x VDDA VDDA sky130_fd_pr__pfet_g5v0d10v5 w=2 l=0.5 nf=1 m=1
xno out x VSS VSS sky130_fd_pr__nfet_g5v0d10v5 w=1 l=0.5 nf=1 m=1
xpb outb y VDDA VDDA sky130_fd_pr__pfet_g5v0d10v5 w=2 l=0.5 nf=1 m=1
xnb outb y VSS VSS sky130_fd_pr__nfet_g5v0d10v5 w=1 l=0.5 nf=1 m=1
.ends
.subckt sspll_cco_dac vgr ibias en c0 c1 c2 c3 c4 VSS
* IBIAS 5 uA -> 2-unit diode; unit sinks 2.5 uA: NBASE always-on units (switch = en) + binary 1..16
xnb ibias ibias VSS VSS sky130_fd_pr__nfet_g5v0d10v5 w=1.000 l=4.0 nf=1 m=2 ad=0.2900 as=0.2900 pd=2.580 ps=2.580
xu0 d0 ibias VSS VSS sky130_fd_pr__nfet_g5v0d10v5 w=1.000 l=4.0 nf=1 m=11 ad=0.2900 as=0.2900 pd=2.580 ps=2.580
xs0 vgr en d0 VSS sky130_fd_pr__nfet_g5v0d10v5 w=1.000 l=0.5 nf=1 m=11 ad=0.2900 as=0.2900 pd=2.580 ps=2.580
xu1 d1 ibias VSS VSS sky130_fd_pr__nfet_g5v0d10v5 w=1.000 l=4.0 nf=1 m=1 ad=0.2900 as=0.2900 pd=2.580 ps=2.580
xs1 vgr c0 d1 VSS sky130_fd_pr__nfet_g5v0d10v5 w=1.000 l=0.5 nf=1 m=1 ad=0.2900 as=0.2900 pd=2.580 ps=2.580
xu2 d2 ibias VSS VSS sky130_fd_pr__nfet_g5v0d10v5 w=1.000 l=4.0 nf=1 m=2 ad=0.2900 as=0.2900 pd=2.580 ps=2.580
xs2 vgr c1 d2 VSS sky130_fd_pr__nfet_g5v0d10v5 w=1.000 l=0.5 nf=1 m=2 ad=0.2900 as=0.2900 pd=2.580 ps=2.580
xu3 d3 ibias VSS VSS sky130_fd_pr__nfet_g5v0d10v5 w=1.000 l=4.0 nf=1 m=4 ad=0.2900 as=0.2900 pd=2.580 ps=2.580
xs3 vgr c2 d3 VSS sky130_fd_pr__nfet_g5v0d10v5 w=1.000 l=0.5 nf=1 m=4 ad=0.2900 as=0.2900 pd=2.580 ps=2.580
xu4 d4 ibias VSS VSS sky130_fd_pr__nfet_g5v0d10v5 w=1.000 l=4.0 nf=1 m=8 ad=0.2900 as=0.2900 pd=2.580 ps=2.580
xs4 vgr c3 d4 VSS sky130_fd_pr__nfet_g5v0d10v5 w=1.000 l=0.5 nf=1 m=8 ad=0.2900 as=0.2900 pd=2.580 ps=2.580
xu5 d5 ibias VSS VSS sky130_fd_pr__nfet_g5v0d10v5 w=1.000 l=4.0 nf=1 m=16 ad=0.2900 as=0.2900 pd=2.580 ps=2.580
xs5 vgr c4 d5 VSS sky130_fd_pr__nfet_g5v0d10v5 w=1.000 l=0.5 nf=1 m=16 ad=0.2900 as=0.2900 pd=2.580 ps=2.580
.ends
.subckt sspll_cco VDDA VDDD VDDL VSS vring ibias vtest code0 code1 code2 code3 code4 pll_en vtest_en
xls0 code0 c0 c0b VDDD VDDA VSS sspll_ls_1v8_3v3
xls1 code1 c1 c1b VDDD VDDA VSS sspll_ls_1v8_3v3
xls2 code2 c2 c2b VDDD VDDA VSS sspll_ls_1v8_3v3
xls3 code3 c3 c3b VDDD VDDA VSS sspll_ls_1v8_3v3
xls4 code4 c4 c4b VDDD VDDA VSS sspll_ls_1v8_3v3
xlsen pll_en en enb VDDD VDDA VSS sspll_ls_1v8_3v3
xlsvt vtest_en vt vtb VDDD VDDA VSS sspll_ls_1v8_3v3
xdac vgr ibias en c0 c1 c2 c3 c4 VSS sspll_cco_dac
xmref vgr vgr VDDA VDDA sky130_fd_pr__pfet_g5v0d10v5 w=40.000 l=2.0 nf=2 m=1 ad=5.8000 as=11.6000 pd=40.580 ps=81.160
xmout vring vgo VDDA VDDA sky130_fd_pr__pfet_g5v0d10v5 w=40.000 l=2.0 nf=2 m=25 ad=5.8000 as=11.6000 pd=40.580 ps=81.160
xrf0 vgr rf1 VSS sky130_fd_pr__res_xhigh_po_0p35 l=87.48 mult=1 m=1
xrf1 rf1 rf2 VSS sky130_fd_pr__res_xhigh_po_0p35 l=87.48 mult=1 m=1
xrf2 rf2 rf3 VSS sky130_fd_pr__res_xhigh_po_0p35 l=87.48 mult=1 m=1
xrf3 rf3 rf4 VSS sky130_fd_pr__res_xhigh_po_0p35 l=87.48 mult=1 m=1
xrf4 rf4 rf5 VSS sky130_fd_pr__res_xhigh_po_0p35 l=87.48 mult=1 m=1
xrf5 rf5 rf6 VSS sky130_fd_pr__res_xhigh_po_0p35 l=87.48 mult=1 m=1
xrf6 rf6 rf7 VSS sky130_fd_pr__res_xhigh_po_0p35 l=87.48 mult=1 m=1
xrf7 rf7 rf8 VSS sky130_fd_pr__res_xhigh_po_0p35 l=87.48 mult=1 m=1
xrf8 rf8 rf9 VSS sky130_fd_pr__res_xhigh_po_0p35 l=87.48 mult=1 m=1
xrf9 rf9 rf10 VSS sky130_fd_pr__res_xhigh_po_0p35 l=87.48 mult=1 m=1
xrf10 rf10 rf11 VSS sky130_fd_pr__res_xhigh_po_0p35 l=87.48 mult=1 m=1
xrf11 rf11 rf12 VSS sky130_fd_pr__res_xhigh_po_0p35 l=87.48 mult=1 m=1
xrf12 rf12 rf13 VSS sky130_fd_pr__res_xhigh_po_0p35 l=87.48 mult=1 m=1
xrf13 rf13 rf14 VSS sky130_fd_pr__res_xhigh_po_0p35 l=87.48 mult=1 m=1
xrf14 rf14 rf15 VSS sky130_fd_pr__res_xhigh_po_0p35 l=87.48 mult=1 m=1
xrf15 rf15 rf16 VSS sky130_fd_pr__res_xhigh_po_0p35 l=87.48 mult=1 m=1
xrf16 rf16 rf17 VSS sky130_fd_pr__res_xhigh_po_0p35 l=87.48 mult=1 m=1
xrf17 rf17 rf18 VSS sky130_fd_pr__res_xhigh_po_0p35 l=87.48 mult=1 m=1
xrf18 rf18 rf19 VSS sky130_fd_pr__res_xhigh_po_0p35 l=87.48 mult=1 m=1
xrf19 rf19 vgo VSS sky130_fd_pr__res_xhigh_po_0p35 l=87.48 mult=1 m=1
xcf vgo VDDA sky130_fd_pr__cap_mim_m3_1 w=30.0 l=30.0 m=4
xpen vgo en VDDA VDDA sky130_fd_pr__pfet_g5v0d10v5 w=2.000 l=0.5 nf=1 m=1 ad=0.5800 as=0.5800 pd=4.580 ps=4.580
xnen ibias enb VSS VSS sky130_fd_pr__nfet_g5v0d10v5 w=2.000 l=0.5 nf=1 m=1 ad=0.5800 as=0.5800 pd=4.580 ps=4.580
xurep vcl ibias VSS VSS sky130_fd_pr__nfet_g5v0d10v5 w=1.000 l=4.0 nf=1 m=1 ad=0.2900 as=0.2900 pd=2.580 ps=2.580
xprep vcl vcl VDDL VDDL sky130_fd_pr__pfet_01v8 w=1.000 l=0.15 nf=1 m=1 ad=0.2900 as=0.2900 pd=2.580 ps=2.580
xpsen vsn vcl vring vring sky130_fd_pr__pfet_01v8 w=1.000 l=0.15 nf=1 m=1 ad=0.2900 as=0.2900 pd=2.580 ps=2.580
xrs vsn VSS VSS sky130_fd_pr__res_xhigh_po_0p35 l=56.0 mult=1 m=1
xnsh vring vsn VSS VSS sky130_fd_pr__nfet_01v8 w=20.000 l=0.15 nf=4 m=1 ad=2.9000 as=4.3500 pd=21.160 ps=31.740
xtgn vtest vt vinj VSS sky130_fd_pr__nfet_g5v0d10v5 w=2.000 l=0.5 nf=1 m=1 ad=0.5800 as=0.5800 pd=4.580 ps=4.580
xtgp vtest vtb vinj VDDA sky130_fd_pr__pfet_g5v0d10v5 w=2.000 l=0.5 nf=1 m=1 ad=0.5800 as=0.5800 pd=4.580 ps=4.580
xrinj vinj vring VSS sky130_fd_pr__res_xhigh_po_0p35 l=3.39 mult=1 m=1
.ends
