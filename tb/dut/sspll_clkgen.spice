* sspll_clkgen (step 77): ports refclk cks cksb ckh ckhb ckg ckgb VDD VSS
.subckt sspll_ckg_drv in o ob VDD VSS
* complementary driver: o follows in (2 stages), ob is inverted (3 stages)
xxan a1 in VSS VSS sky130_fd_pr__nfet_01v8 w=0.420 l=0.15 nf=1 m=1 ad=0.1218 as=0.1218 pd=1.420 ps=1.420
xxap a1 in VDD VDD sky130_fd_pr__pfet_01v8 w=0.840 l=0.15 nf=1 m=1 ad=0.2436 as=0.2436 pd=2.260 ps=2.260
xxbn o a1 VSS VSS sky130_fd_pr__nfet_01v8 w=4.000 l=0.15 nf=2 m=1 ad=0.5800 as=1.1600 pd=4.580 ps=9.160
xxbp o a1 VDD VDD sky130_fd_pr__pfet_01v8 w=8.000 l=0.15 nf=2 m=1 ad=1.1600 as=2.3200 pd=8.580 ps=17.160
xxcn c1 in VSS VSS sky130_fd_pr__nfet_01v8 w=0.420 l=0.15 nf=1 m=1 ad=0.1218 as=0.1218 pd=1.420 ps=1.420
xxcp c1 in VDD VDD sky130_fd_pr__pfet_01v8 w=0.840 l=0.15 nf=1 m=1 ad=0.2436 as=0.2436 pd=2.260 ps=2.260
xxdn c2 c1 VSS VSS sky130_fd_pr__nfet_01v8 w=1.000 l=0.15 nf=1 m=1 ad=0.2900 as=0.2900 pd=2.580 ps=2.580
xxdp c2 c1 VDD VDD sky130_fd_pr__pfet_01v8 w=2.000 l=0.15 nf=1 m=1 ad=0.5800 as=0.5800 pd=4.580 ps=4.580
xxen ob c2 VSS VSS sky130_fd_pr__nfet_01v8 w=4.000 l=0.15 nf=2 m=1 ad=0.5800 as=1.1600 pd=4.580 ps=9.160
xxep ob c2 VDD VDD sky130_fd_pr__pfet_01v8 w=8.000 l=0.15 nf=2 m=1 ad=1.1600 as=2.3200 pd=8.580 ps=17.160
.ends
.subckt sspll_ckg_pulse_h in out VDD VSS
* RC pulser: out = in AND NOT(in delayed by the R-C stage), i.e. a pulse at every rising edge of in
xx1n inb in VSS VSS sky130_fd_pr__nfet_01v8 w=0.420 l=0.15 nf=1 m=1 ad=0.1218 as=0.1218 pd=1.420 ps=1.420
xx1p inb in VDD VDD sky130_fd_pr__pfet_01v8 w=0.840 l=0.15 nf=1 m=1 ad=0.2436 as=0.2436 pd=2.260 ps=2.260
xx2n drc in VSS VSS sky130_fd_pr__nfet_01v8 w=0.420 l=0.15 nf=1 m=1 ad=0.1218 as=0.1218 pd=1.420 ps=1.420
xx2p drc in VDD VDD sky130_fd_pr__pfet_01v8 w=0.840 l=0.15 nf=1 m=1 ad=0.2436 as=0.2436 pd=2.260 ps=2.260
xr drc rc VSS sky130_fd_pr__res_xhigh_po_0p35 l=6.0 mult=1 m=1
xc rc VSS sky130_fd_pr__cap_mim_m3_1 w=6.0 l=6.0 m=1
xx3n dly rc VSS VSS sky130_fd_pr__nfet_01v8 w=0.420 l=0.15 nf=1 m=1 ad=0.1218 as=0.1218 pd=1.420 ps=1.420
xx3p dly rc VDD VDD sky130_fd_pr__pfet_01v8 w=0.840 l=0.15 nf=1 m=1 ad=0.2436 as=0.2436 pd=2.260 ps=2.260
xx4na out inb VSS VSS sky130_fd_pr__nfet_01v8 w=0.840 l=0.15 nf=1 m=1 ad=0.2436 as=0.2436 pd=2.260 ps=2.260
xx4nb out dly VSS VSS sky130_fd_pr__nfet_01v8 w=0.840 l=0.15 nf=1 m=1 ad=0.2436 as=0.2436 pd=2.260 ps=2.260
xx4pa x4_x inb VDD VDD sky130_fd_pr__pfet_01v8 w=1.680 l=0.15 nf=1 m=1 ad=0.4872 as=0.4872 pd=3.940 ps=3.940
xx4pb out dly x4_x VDD sky130_fd_pr__pfet_01v8 w=1.680 l=0.15 nf=1 m=1 ad=0.4872 as=0.4872 pd=3.940 ps=3.940
.ends
.subckt sspll_ckg_pulse_g in out VDD VSS
* RC pulser: out = in AND NOT(in delayed by the R-C stage), i.e. a pulse at every rising edge of in
xx1n inb in VSS VSS sky130_fd_pr__nfet_01v8 w=0.420 l=0.15 nf=1 m=1 ad=0.1218 as=0.1218 pd=1.420 ps=1.420
xx1p inb in VDD VDD sky130_fd_pr__pfet_01v8 w=0.840 l=0.15 nf=1 m=1 ad=0.2436 as=0.2436 pd=2.260 ps=2.260
xx2n drc in VSS VSS sky130_fd_pr__nfet_01v8 w=0.420 l=0.15 nf=1 m=1 ad=0.1218 as=0.1218 pd=1.420 ps=1.420
xx2p drc in VDD VDD sky130_fd_pr__pfet_01v8 w=0.840 l=0.15 nf=1 m=1 ad=0.2436 as=0.2436 pd=2.260 ps=2.260
xr drc rc VSS sky130_fd_pr__res_xhigh_po_0p35 l=0.5 mult=1 m=1
xc rc VSS sky130_fd_pr__cap_mim_m3_1 w=3.5 l=3.5 m=1
xx3n dly rc VSS VSS sky130_fd_pr__nfet_01v8 w=0.420 l=0.15 nf=1 m=1 ad=0.1218 as=0.1218 pd=1.420 ps=1.420
xx3p dly rc VDD VDD sky130_fd_pr__pfet_01v8 w=0.840 l=0.15 nf=1 m=1 ad=0.2436 as=0.2436 pd=2.260 ps=2.260
xx4na out inb VSS VSS sky130_fd_pr__nfet_01v8 w=0.840 l=0.15 nf=1 m=1 ad=0.2436 as=0.2436 pd=2.260 ps=2.260
xx4nb out dly VSS VSS sky130_fd_pr__nfet_01v8 w=0.840 l=0.15 nf=1 m=1 ad=0.2436 as=0.2436 pd=2.260 ps=2.260
xx4pa x4_x inb VDD VDD sky130_fd_pr__pfet_01v8 w=1.680 l=0.15 nf=1 m=1 ad=0.4872 as=0.4872 pd=3.940 ps=3.940
xx4pb out dly x4_x VDD sky130_fd_pr__pfet_01v8 w=1.680 l=0.15 nf=1 m=1 ad=0.4872 as=0.4872 pd=3.940 ps=3.940
.ends
.subckt sspll_clkgen refclk cks cksb ckh ckhb ckg ckgb VDD VSS
xxi0n r1 refclk VSS VSS sky130_fd_pr__nfet_01v8 w=1.000 l=0.15 nf=1 m=1 ad=0.2900 as=0.2900 pd=2.580 ps=2.580
xxi0p r1 refclk VDD VDD sky130_fd_pr__pfet_01v8 w=2.000 l=0.15 nf=1 m=1 ad=0.5800 as=0.5800 pd=4.580 ps=4.580
xxi1n r2 r1 VSS VSS sky130_fd_pr__nfet_01v8 w=1.000 l=0.15 nf=1 m=1 ad=0.2900 as=0.2900 pd=2.580 ps=2.580
xxi1p r2 r1 VDD VDD sky130_fd_pr__pfet_01v8 w=2.000 l=0.15 nf=1 m=1 ad=0.5800 as=0.5800 pd=4.580 ps=4.580
xds r2 cksb cks VDD VSS sspll_ckg_drv
xxi2n h1 r2 VSS VSS sky130_fd_pr__nfet_01v8 w=0.420 l=0.15 nf=1 m=1 ad=0.1218 as=0.1218 pd=1.420 ps=1.420
xxi2p h1 r2 VDD VDD sky130_fd_pr__pfet_01v8 w=0.840 l=0.15 nf=1 m=1 ad=0.2436 as=0.2436 pd=2.260 ps=2.260
xxi3n h2 h1 VSS VSS sky130_fd_pr__nfet_01v8 w=0.420 l=0.15 nf=1 m=1 ad=0.1218 as=0.1218 pd=1.420 ps=1.420
xxi3p h2 h1 VDD VDD sky130_fd_pr__pfet_01v8 w=0.840 l=0.15 nf=1 m=1 ad=0.2436 as=0.2436 pd=2.260 ps=2.260
xph h2 ph VDD VSS sspll_ckg_pulse_h
xdh ph ckh ckhb VDD VSS sspll_ckg_drv
xxi4n g1 ph VSS VSS sky130_fd_pr__nfet_01v8 w=0.420 l=0.15 nf=1 m=1 ad=0.1218 as=0.1218 pd=1.420 ps=1.420
xxi4p g1 ph VDD VDD sky130_fd_pr__pfet_01v8 w=0.840 l=0.15 nf=1 m=1 ad=0.2436 as=0.2436 pd=2.260 ps=2.260
xxi5n g2 g1 VSS VSS sky130_fd_pr__nfet_01v8 w=0.420 l=0.15 nf=1 m=1 ad=0.1218 as=0.1218 pd=1.420 ps=1.420
xxi5p g2 g1 VDD VDD sky130_fd_pr__pfet_01v8 w=0.840 l=0.15 nf=1 m=1 ad=0.2436 as=0.2436 pd=2.260 ps=2.260
xxi6n g3 g2 VSS VSS sky130_fd_pr__nfet_01v8 w=0.420 l=0.15 nf=1 m=1 ad=0.1218 as=0.1218 pd=1.420 ps=1.420
xxi6p g3 g2 VDD VDD sky130_fd_pr__pfet_01v8 w=0.840 l=0.15 nf=1 m=1 ad=0.2436 as=0.2436 pd=2.260 ps=2.260
xpg g3 pg VDD VSS sspll_ckg_pulse_g
xdg pg ckg ckgb VDD VSS sspll_ckg_drv
.ends
