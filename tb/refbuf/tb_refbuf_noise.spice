* tb_refbuf_noise - method M14: noise of the receiver at its crossing point (step 76)
* Run:  tb/run.sh tb/refbuf/tb_refbuf_noise.spice tt 27
* With no signal the first stage S1 sits at its trip point (input = output, through R_B). That is exactly the
* operating point it passes through at every crossing, so .noise here gives the noise that moves the edges.
* Two analyses:  (1) .noise at s1 (inside the block: node x1.s1),  (2) .ac gain from the gate x1.vin to x1.s1.
* Gate-referred noise = output noise / |gain|. Jitter = gate noise / gate slope (see the guide); the white plateau
* (~3.2 nV/rtHz) is what tb_refbuf_tnoise injects.
.lib __PDK__/libs.tech/ngspice/sky130.lib.spice __CORNER__
.temp __TEMP__
.include __DUT__/sspll_refbuf.spice
vdda VDDA 0 3.3            ; 3.3 V analog supply
vddl VDDL 0 1.8            ; regulated 1.8 V rail (output stages)
vddd VDDD 0 1.8            ; 1.8 V digital supply (level shifter input side)
iib  ib 0 2.5u             ; bias generator: pulls 2.5 uA OUT of the bias diode (current from node ib to 0)
ven  pll_en 0 1.8          ; enabled
vsrc padx 0 dc 1.65 ac 1   ; the oscillator: 50 ohm source at VDDA/2 (ac 1 = noise input reference)
rs   padx pad0 50
x1 pad0 refclk ib pll_en VDDA VDDL VDDD 0 sspll_refbuf
cl refclk 0 50f
.control
option sparse
op
print v(x1.vin) v(x1.s1)               ; the self-bias point (they are equal: R_B carries no DC current)
ac dec 20 1e3 1e10
let a = mag(v(x1.s1)/v(x1.vin))         ; gain of S1
let div = mag(v(x1.vin)/v(pad0))        ; pad -> gate divider of C_AC (signal attenuation)
meas ac a_1m  find a at=1e6
meas ac a_300m find a at=3e8
meas ac div50 find div at=5e7
set a1m = "$&a_1m"                        ; shell variables survive the change of plot below
set a300m = "$&a_300m"
set d50 = "$&div50"
noise v(x1.s1) vsrc dec 20 1e3 1e10
setplot noise1
wrdata s1_noise.txt onoise_spectrum     ; output noise at s1, V/rtHz
noise v(x1.s1) vsrc lin 1 1e6 1e6
let g1m = onoise_spectrum/$a1m
set gg1 = "$&g1m"
noise v(x1.s1) vsrc lin 1 3e8 3e8
let g300m = onoise_spectrum/$a300m
echo "RESULT gate-referred noise: $gg1 V/rtHz at 1 MHz, $&g300m V/rtHz at 300 MHz; C_AC divider at 50 MHz = $d50"
.endc
.end
