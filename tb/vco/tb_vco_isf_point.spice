* tb_vco_isf_point - method M2, one point of the impulse sensitivity function (ISF) (step 74)
* Run:  tb/run.sh tb/vco/tb_vco_isf_point.spice tt 27
* A charge q = 2 fC is injected into the ring node vop at time tinj. Run 1: no injection; run 2: with injection.
* The difference in a zero-crossing time long after the kick is a permanent phase shift:
*     dphi = 2 pi f dt,      ISF  h(tinj) = dphi / q   (rad/C)
* design/vco/vco.py: isf_noise() repeats this for 12 injection times over one period and for every ring node,
* and combines h with each device's noise (method M3) into phase noise (Hajimiri-Lee).

.lib __PDK__/libs.tech/ngspice/sky130.lib.spice __CORNER__
.temp __TEMP__
.include __DUT__/sspll_vco.spice
.param cpar=10f
vss VSS 0 0
vbuf VDDBUF 0 1.8
vtn vtune 0 0.9
ivco 0 vring dc 1.437m
cdec vring 0 0.5p
x1 vring vtune VDDBUF VSS vop vom clkp clkm sspll_vco
* charge kick: a 1 ps current pulse of 2 mA = 2 fC (amplitude 0 in the first run)
iinj VSS vop pulse(0 0 10.2n 0.1p 0.1p 0.9p 1)
.ic v(vring)=1.3 v(vop)=0 v(vom)=1.3

.control
option noinit
tran 1.5p 20n 0 1.5p uic
let vd = v(vop) - v(vom)
meas tran ta when vd=0 rise=10
meas tran t0 when vd=0 rise=26
let f = 16/(t0 - ta)
set fosc = "$&f"                                       ; keep the results of run 1 (the next tran opens a new plot)
set tref = "$&t0"
alter @iinj[pulse] = [ 0 2m 10.2n 0.1p 0.1p 0.9p 1 ]   ; now with the kick
tran 1.5p 20n 0 1.5p uic
let vd = v(vop) - v(vom)
meas tran t1 when vd=0 rise=26
let dt = t1 - $tref
let dphi = 2*pi*$fosc*dt
let h = dphi/2e-15
echo "RESULT f = $fosc Hz, dt = $&dt s, dphi = $&dphi rad, h = $&h rad/C (kick at 10.2 ns)"
.endc
.end
