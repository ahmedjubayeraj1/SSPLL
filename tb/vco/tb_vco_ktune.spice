* tb_vco_ktune - method M1 over the fine-tune voltage: f(vtune) and K_VCO = df/dvtune (step 74)
* Run:  tb/run.sh tb/vco/tb_vco_ktune.spice tt 27
* K_VCO is negative: a higher vtune turns the switches XS harder on and hangs more of the MOS capacitors XC on the
* ring nodes. Below about 0.7 V the switches turn off and the curve flattens -> lock window 0.7-1.2 V.

.lib __PDK__/libs.tech/ngspice/sky130.lib.spice __CORNER__
.temp __TEMP__
.include __DUT__/sspll_vco.spice
.param cpar=10f
vss VSS 0 0
vbuf VDDBUF 0 1.8
vtn vtune 0 0.9
ivco 0 vring dc 1.437m
cdec vring 0 0.5p
x1 vring vtune VDDBUF VSS vop vom clkp clkm sspll_vco
.ic v(vring)=1.3 v(vop)=0 v(vom)=1.3

.control
option noinit
echo "RESULT  vtune(V)  f(Hz)"
foreach vt 0.5 0.6 0.7 0.8 0.9 1.0 1.1 1.2 1.3
  alter vtn dc = $vt
  tran 2p 26n 0 2p uic
  let vd = v(vop) - v(vom)
  meas tran ta when vd=0 rise=12
  meas tran tb when vd=0 rise=32
  let f = 20/(tb - ta)
  echo "RESULT $vt $&f"
  destroy all
end
.endc
.end
