* tb_vco_tran - method M1: oscillation frequency and ring-supply voltage at one feed current (step 74)
* Run:  tb/run.sh tb/vco/tb_vco_tran.spice tt 27        (corner and temperature are the 2nd and 3rd arguments)
*
* Idea: a ring oscillator has no small-signal operating point, so only a transient shows its frequency. The CCO is
* replaced by an ideal current source (we want the ring alone); the ring settles at the supply voltage where it draws
* exactly that current. After start-up (12 cycles) we time 20 rising zero-crossings of the differential output.

.lib __PDK__/libs.tech/ngspice/sky130.lib.spice __CORNER__
.temp __TEMP__
.include __DUT__/sspll_vco.spice

.param cpar=10f          ; layout estimate: extra capacitance on every ring output node
.param ivco=1.437m       ; feed current (the step-74 value for 1.6 GHz at tt)

vss    VSS    0  0
vbuf   VDDBUF 0  1.8     ; supply of the AC-coupled output buffers
vtn    vtune  0  0.9     ; fine-tune control at the middle of the lock window (0.7-1.2 V)
ivco   0 vring dc {ivco} ; ideal "CCO": current flows from 0 into node vring (the ring's supply node)
cdec   vring  0  0.5p    ; small decoupling, like the routing capacitance of the real node
x1 vring vtune VDDBUF VSS vop vom clkp clkm sspll_vco

* start-up kick: an unbalanced initial condition so the ring does not sit in its metastable (all-equal) state
.ic v(vring)=1.3 v(vop)=0 v(vom)=1.3

.control
option noinit
tran 2p 26n 0 2p uic                      ; 2 ps step, 26 ns, use the .ic values (uic)
let vd = v(vop) - v(vom)                  ; differential output
meas tran ta when vd=0 rise=12            ; 12th rising zero-crossing (start-up is over)
meas tran tb when vd=0 rise=32            ; 32nd
let f = 20/(tb - ta)                      ; 20 periods between them
meas tran vring_avg avg v(vring) from=ta to=tb   ; ring-supply voltage (must stay <= 1.8 V)
meas tran vring_max max v(vring) from=ta to=tb
meas tran swing pp vd from=ta to=tb      ; differential swing
echo "RESULT f = $&f Hz, vring avg = $&vring_avg V, max = $&vring_max V, diff swing = $&swing V"
.endc
.end
