* tb_cco_psr - method M11: how much of a VDDA ripple reaches the ring as current (step 75)
* Run:  tb/run.sh tb/cco/tb_cco_psr.spice tt 27
* An AC analysis with "ac 1" on VDDA: the small-signal ring current |i(vr)| is then directly in A per V of ripple
* (= uA/mV after scaling). The filter capacitor to VDDA makes the output gate follow VDDA, which keeps this small.
.lib __PDK__/libs.tech/ngspice/sky130.lib.spice __CORNER__
.temp __TEMP__
.include __DUT__/sspll_cco.spice
vdda VDDA 0 dc 3.3 ac 1        ; 1 V AC on the supply (small-signal, so the size does not matter)
vddd VDDD 0 1.8
vddl VDDL 0 1.8
iib  0 ibias 5u
vt   vtest 0 1.45
ven  pll_en 0 1.8
vvt  vtest_en 0 0
vr   vring 0 1.45
vc0 code0 0 0
vc1 code1 0 1.8
vc2 code2 0 0
vc3 code3 0 1.8
vc4 code4 0 0
x1 VDDA VDDD VDDL 0 vring ibias vtest code0 code1 code2 code3 code4 pll_en vtest_en sspll_cco
.control
ac dec 10 1e3 1e8
let psr = mag(i(vr))
meas ac psr_10k find psr at=1e4
meas ac psr_1m  find psr at=1e6
meas ac psr_10m find psr at=1e7
echo "RESULT |dI/dVDDA| at 10 kHz / 1 MHz / 10 MHz = $&psr_10k $&psr_1m $&psr_10m A/V"
.endc
.end
