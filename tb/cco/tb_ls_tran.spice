* tb_ls_tran - method M13: 1.8 V -> 3.3 V level shifter at its hardest supplies (step 75)
* Run:  tb/run.sh tb/cco/tb_ls_tran.spice ss 110      and   ff -40
* The cross-coupled latch only flips if the nMOS pull-downs (gate swing = VDDD, low) beat the pMOS loads (on VDDA,
* high). Hardest: lowest VDDD 1.71 V with highest VDDA 3.63 V. A pulse on "in"; the outputs must reach full swing.
.lib __PDK__/libs.tech/ngspice/sky130.lib.spice __CORNER__
.temp __TEMP__
.include __DUT__/sspll_cco.spice
vdda VDDA 0 3.63
vddd VDDD 0 1.71
vin  in 0 pulse(0 1.71 1n 0.2n 0.2n 20n 40n)
x1 in out outb VDDD VDDA 0 sspll_ls_1v8_3v3
cl1 out 0 20f
cl2 outb 0 20f
.control
tran 10p 80n
meas tran tr trig v(out) val=0.363 rise=1 targ v(out) val=3.267 rise=1     ; 10-90 % of 3.63 V
meas tran tf trig v(out) val=3.267 fall=1 targ v(out) val=0.363 fall=1
meas tran tpd trig v(in) val=0.855 rise=1 targ v(out) val=1.815 rise=1
meas tran vhi max v(out) from=10n to=20n
meas tran vlo min v(out) from=30n to=40n
echo "RESULT rise $&tr s, fall $&tf s, delay $&tpd s, high $&vhi V, low $&vlo V"
.endc
.end
