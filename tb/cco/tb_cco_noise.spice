* tb_cco_noise - method M11: output current noise of the complete CCO (step 75)
* Run:  tb/run.sh tb/cco/tb_cco_noise.spice tt 27
* .noise linearises every device at its operating point and adds their thermal, flicker and resistor noise through
* the exact transfer functions to the output. The output must be a voltage, so the current into the ring node is
* measured by a 0 V source (vm) and converted 1 V/A by a CCVS (h1): v(o) in V/rtHz = output current in A/rtHz.
* "iib" carries "ac 1" because .noise needs a named input source (it also reports input-referred noise).
.lib __PDK__/libs.tech/ngspice/sky130.lib.spice __CORNER__
.temp __TEMP__
.include __DUT__/sspll_cco.spice
vdda VDDA 0 3.3
vddd VDDD 0 1.8
vddl VDDL 0 1.8
iib  0 ibias dc 5u ac 1
vt   vtest 0 1.45
ven  pll_en 0 1.8
vvt  vtest_en 0 0
vr   vring 0 1.45
vm   vr2 vring 0               ; ammeter between the CCO output and the ring source
h1   o 0 vm 1                  ; o = output current (A -> V)
vc0 code0 0 0
vc1 code1 0 1.8
vc2 code2 0 0
vc3 code3 0 1.8                ; code 10 (01010)
vc4 code4 0 0
x1 VDDA VDDD VDDL 0 vr2 ibias vtest code0 code1 code2 code3 code4 pll_en vtest_en sspll_cco
.control
option sparse
noise v(o) iib dec 10 1e3 1e8
setplot noise1
wrdata cco_noise.txt onoise_spectrum      ; columns: f  A/rtHz
noise v(o) iib lin 1 1e6 1e6               ; one point at 1 MHz (requirement <= 10.3 pA/rtHz)
print onoise_spectrum
noise v(o) iib lin 1 1e4 1e4
print onoise_spectrum
echo "RESULT the two values above are the output noise at 1 MHz and 10 kHz (A/rtHz)"
.endc
.end
