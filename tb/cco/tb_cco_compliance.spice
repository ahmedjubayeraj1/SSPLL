* tb_cco_compliance - method M10: does the output stay a current source over the ring-node range? (step 75)
* Run:  tb/run.sh tb/cco/tb_cco_compliance.spice ss 110   (set vdda to 2.97 V and iib to 4u below for the worst case)
* A DC sweep of the ring-node voltage at code 31: the current must stay flat from 0 V up to ~1.8 V (the output pMOS
* stays saturated). Above VDDL (1.8 V) the clamp starts to sink current, so the curve bends down and goes negative.
.lib __PDK__/libs.tech/ngspice/sky130.lib.spice __CORNER__
.temp __TEMP__
.include __DUT__/sspll_cco.spice
vdda VDDA 0 3.3           ; 3.3 V analog supply (change to 2.97 / 3.63 for the supply corners)
vddd VDDD 0 1.8           ; 1.8 V digital supply (drives the level shifters)
vddl VDDL 0 1.8           ; regulated 1.8 V rail (clamp reference)
iib  0 ibias 5u           ; IBIAS: 5 uA flowing INTO the block (current source from node 0 to ibias)
vt   vtest 0 1.45         ; VTEST pad (not used here)
ven  pll_en 0 1.8         ; block enabled
vvt  vtest_en 0 0         ; VTEST injection off
vr   vring 0 1.45
vc0 code0 0 1.8
vc1 code1 0 1.8
vc2 code2 0 1.8
vc3 code3 0 1.8
vc4 code4 0 1.8
x1 VDDA VDDD VDDL 0 vring ibias vtest code0 code1 code2 code3 code4 pll_en vtest_en sspll_cco
.control
dc vr 0 2.4 0.05                         ; sweep the ring-node voltage
let iout = i(vr)                  ; positive = current delivered into the ring node
wrdata compliance.txt iout                ; columns: v(vring)  I_out
meas dc i_0v4 find iout at=0.4
meas dc i_1v4 find iout at=1.4
meas dc i_1v7 find iout at=1.7
meas dc i_1v8 find iout at=1.8
echo "RESULT I at 0.4 / 1.4 / 1.7 / 1.8 V = $&i_0v4 $&i_1v4 $&i_1v7 $&i_1v8 A"
.endc
.end
