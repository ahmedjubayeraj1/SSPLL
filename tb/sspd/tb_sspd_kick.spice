* tb_sspd_kick - method M19: kick-back of the SSPD into the VCO outputs, and the dummy sampler's job (step 78)
* Run:  tb/run.sh tb/sspd/tb_sspd_kick.spice tt 27
*       python3 tb/sspd_kick.py tb/out/tb_sspd_kick/a.txt tb/out/tb_sspd_kick/b.txt
* Idea: run the same circuit twice at f = 32 x 50 MHz (locked frequency), with the VCO phase set so that sampling
* happens near the zero crossing (lock point). Run a: clock generator working. Run b: refclk held at 0, so the sampler
* just tracks and nothing switches. The difference of the clkp edge times (a - b) is what the sampler's switching does
* to the VCO output: its component at f_ref, as a phase 2 pi f0 dt, estimates the reference spur.
* The SSPD supply current is also saved: its f_ref component is the ripple the SSPD would put on the LDO rail.
* To see the dummy sampler's job, make CD tiny in tb/dut/sspll_sspd.spice (xcd ... w=2 l=2) and rerun: ~55x more.
.lib __PDK__/libs.tech/ngspice/sky130.lib.spice __CORNER__
.temp __TEMP__
.include __DUT__/sspll_clkgen.spice
.include __DUT__/sspll_sspd.spice
.param fv=1.6e9 tv={1/fv} td=473p
vdd VDD 0 1.8
vck VCK 0 1.8
vdrv VDRV 0 1.8
vvp vp 0 pulse(0 1.8 {td} 40p 40p {tv/2 - 40p} {tv})
vvm vm 0 pulse(1.8 0 {td} 40p 40p {tv/2 - 40p} {tv})
xdpn clkp vp 0 0 sky130_fd_pr__nfet_01v8 w=2 l=0.15 nf=1
xdpp clkp vp VDRV VDRV sky130_fd_pr__pfet_01v8 w=4 l=0.15 nf=1
xdmn clkm vm 0 0 sky130_fd_pr__nfet_01v8 w=2 l=0.15 nf=1
xdmp clkm vm VDRV VDRV sky130_fd_pr__pfet_01v8 w=4 l=0.15 nf=1
cclp clkp 0 10f
cclm clkm 0 10f
vin refclk 0 pulse(0 1.8 5n 375p 375p 9.625n 20n)
xcg refclk cks cksb ckh ckhb ckg ckgb VCK 0 sspll_clkgen
xpd clkp clkm v1p v1m v2p v2m cks cksb ckh ckhb VDD 0 sspll_sspd
cg1 v1p 0 6f
cg2 v1m 0 6f
cn1 v2p 0 4f
cn2 v2m 0 4f
cckg ckg 0 20f
cckgb ckgb 0 20f
.control
option interp
tran 1p 140n
wrdata a.txt v(clkp) i(vdd) v(cks) v(v1p) v(v1m)
alter @vin[pulse] = [ 0 0 5n 375p 375p 9.625n 20n ]
tran 1p 140n
wrdata b.txt v(clkp) i(vdd) v(cks) v(v1p) v(v1m)
echo "RESULT now run: python3 tb/sspd_kick.py tb/out/tb_sspd_kick/a.txt tb/out/tb_sspd_kick/b.txt"
.endc
.end
